[IBIS Ver]   4.2
[File Name]  logical_RTL.ibs
[File Rev]   3.0
[Date]   November 03, 2017
[Source]   Altera Corporation
[Notes]   - The models are designated as "Final" and have been correlated against physical device operation.
   - This IBIS model is checked using IBISCHK v5.0.4
   There are no known errors and warnings reported.
   - There are no known limitations for this IBIS model release.
   - Contact point: Altera Corporation, http://www.altera.com/corporate/contact/con-index.html
   - This file is generated using Quartus II Version 17.0.0 Build 595 04/25/2017 SJ Lite Edition
   - Unused IOs which have been assigned as tri-stated inputs or as outputs driving any signal in Quartus II
   arerepresented by the NC.
   - Only general purpose IBIS models are supported.
   Revision History
   - v1.0
   - Initial release of MAX 10 IBIS models. Models are based on pre-layout and early engineering info.
   - v2.0
   - Models are based on post-layout, may be missing certain features.
   - v3.0
   - Models have undergone final correlation against physical device operation.
[Disclaimer] Data is for modeling purposes only and is not guaranteed.
[Copyright]  Copyright (C) 2017  Intel Corporation. All rights reserved.
[Component]  10M04SCE144I7G_logical_RTL
[Manufacturer] Altera Corporation
[Package]
| RLC values are for 144 EQFP package
| variable  typ   min   max
R_pkg   289m   242m   363m
L_pkg   6.79nH   4.29nH   8.00nH
C_pkg   1.33pF   1.19pF   1.65pF
[Pin] signal_name   model_name   R_pin   L_pin   C_pin
1   VCC_ONE   POWER
10   Inv_Pwm_LMTU   33schmitttrig_rin_p   260.4m   7.339nH   1.357pF
100   Rec_Pwm_AP   lvcmos_rio_d2s2   291.8m   7.332nH   1.403pF
101   Inv_Pwm_U4   lvcmos_rio_d2s2   292.3m   6.985nH   1.435pF
102   Inv_Pwm_U3   lvcmos_rio_d2s2   324.2m   6.610nH   1.479pF
103   VCCIO6   POWER
104   GND   GND
105   Inv_Pwm_U2   lvcmos_rio_d2s2   328.6m   5.949nH   1.581pF
106   Inv_Pwm_U1   lvcmos_rio_d2s2   333.1m   6.503nH   1.611pF
107   VCCA3   POWER
108   VCC_ONE   POWER
109   VCC_ONE   POWER
11   RecSCR_CN   lvcmos_rio_d2s2   270.7m   7.411nH   1.334pF
110   AUX_Fault   33schmitttrig_cin_p   359.5m   6.401nH   1.625pF
111   RSTn   33schmitttrig_cin_p   349.8m   7.176nH   1.642pF
112   Inv_SPISOMI   lvcmos_cio_d2s2_vref   359.6m   7.628nH   1.589pF
113   LBS_SYNC   lvcmos_cio_d2s2   359.7m   6.886nH   1.570pF
114   EPO   33schmitttrig_cin_p   345.8m   5.565nH   1.540pF
115   VCC_ONE   POWER
116   GND   GND
117   VCCIO7   POWER
118   SER_BUS_TX   lvcmos_cio_d2s2   314.4m   6.660nH   1.393pF
119   SER_BUS_RX   33schmitttrig_cin_p   308.6m   6.855nH   1.354pF
12   RecSCR_CP   lvcmos_rio_d2s2   272.2m   7.261nH   1.302pF
120   Inv_SPISIMO   33schmitttrig_cin_p   308.2m   7.147nH   1.327pF
123   Inv_SPICLK   33schmitttrig_cin_p   305.5m   6.523nH   1.265pF
124   Inv_SPISTE   33schmitttrig_cin_p   321.6m   5.945nH   1.245pF
125   GND   GND
127   Inv_CrossZero_W   33schmitttrig_cin_p   309.6m   5.973nH   1.255pF
128   VCCIO8   POWER
13   RecSCR_BP   lvcmos_rio_d2s2   257.9m   6.987nH   1.270pF
130   Rec_SCIRX   33schmitttrig_cin_p   278.4m   6.468nH   1.237pF
131   Inv_CrossZero_V   33schmitttrig_cin_p   282.3m   6.331nH   1.258pF
132   Inv_CrossZero_U   33schmitttrig_cin_p   280.7m   5.599nH   1.277pF
133   GND   GND
135   Inv_Pwm_U   33schmitttrig_cin_p   292.6m   6.322nH   1.363pF
137   GND   GND
139   VCCIO8   POWER
14   RecSCR_AN   lvcmos_rio_d2s2   245.8m   7.071nH   1.231pF
140   Inv_Pwm_W   33schmitttrig_cin_p   336.4m   6.287nH   1.561pF
141   Inv_Pwm_V   33schmitttrig_cin_p   343.8m   6.182nH   1.588pF
142   GND   GND
143   VCCA4   POWER
144   VCC_ONE   POWER
16   altera_reserved_tms   33schmitttrig_rin   257.7m   7.170nH   1.210pF
17   RecSCR_BN   lvcmos_rio_d2s2_vref   268.5m   7.329nH   1.211pF
18   altera_reserved_tck   33schmitttrig_rin   266.6m   7.075nH   1.218pF
19   altera_reserved_tdi   33schmitttrig_rin   248.4m   6.966nH   1.204pF
2   VCCA6   POWER
20   altera_reserved_tdo   lvttl_rio_s2   242.0m   7.006nH   1.199pF
21   RecSCR_AP   lvcmos_rio_d2s2   243.4m   7.066nH   1.198pF
22   Rec_Charger_OVTemp   33schmitttrig_rin_p   247.5m   7.072nH   1.221pF
23   VCCIO1B   POWER
24   BAT_SCR   lvttl_rio_d8s2   276.4m   7.264nH   1.289pF
25   DCBUS_OV   33schmitttrig_rin_p   280.1m   7.336nH   1.310pF
27   CLK   33schmitttrig_rin_p   270.4m   7.422nH   1.367pF
29   IchgN_LMT   33schmitttrig_rin_p   289.4m   7.504nH   1.439pF
3   GND   GND
30   IGBT_Temp_OV   33schmitttrig_rin_p   313.0m   7.997nH   1.459pF
31   VCCIO2   POWER
32   Rec_SPICLK   33schmitttrig_rin_p   317.0m   7.576nH   1.557pF
33   Rec_SPISTE   33schmitttrig_rin_p   324.4m   7.429nH   1.584pF
34   VCCA2   POWER
35   VCCA1   POWER
36   VCC_ONE   POWER
37   VCC_ONE   POWER
38   IchgP_LMT   33schmitttrig_cin_p   363.2m   6.081nH   1.622pF
39   ICN_LMT   33schmitttrig_cin_p   360.7m   6.350nH   1.650pF
4   GND   GND
40   VCCIO3   POWER
41   IBN_LMT   33schmitttrig_cin_p   344.5m   5.651nH   1.562pF
42   GND   GND
43   ICP_LMT   33schmitttrig_cin_p   322.4m   5.972nH   1.478pF
44   IAN_LMT   33schmitttrig_cin_p   320.9m   6.746nH   1.453pF
45   Rec_SPISIMO   33schmitttrig_cin_p   311.0m   6.930nH   1.410pF
46   Rec_SCITX   lvcmos_cio_d2s2   285.6m   6.797nH   1.363pF
47   Rec_SPISOMI   lvcmos_cio_d2s2   281.0m   6.564nH   1.329pF
48   RecCharger_OV   33schmitttrig_cin_p   309.1m   6.310nH   1.306pF
49   VCCIO3   POWER
5   VCCA3   POWER
50   IBP_LMT   33schmitttrig_cin_p   270.9m   4.747nH   1.246pF
51   VCC_ONE   POWER
52   IAP_LMT   33schmitttrig_cin_p   267.7m   4.287nH   1.211pF
53   GND   GND
54   Inv_FuseFault   33schmitttrig_cin_p   287.7m   5.363nH   1.241pF
55   Rec_BoostSCR_OVTemp   33schmitttrig_cin_p   264.6m   6.124nH   1.230pF
56   Rec_HeatSink_OVTemp   33schmitttrig_cin_p   257.4m   6.446nH   1.210pF
57   Inv_HeatSink_OVTemp   33schmitttrig_cin_p   260.0m   6.627nH   1.210pF
58   Rec_Pwm2   33schmitttrig_cin_p   271.6m   6.593nH   1.236pF
59   Rec_Pwm3   33schmitttrig_cin_p   285.8m   6.836nH   1.261pF
6   Vout_CrossZero   33schmitttrig_rin_p   296.0m   7.524nH   1.505pF
60   Rec_Pwm1   33schmitttrig_cin_p   283.8m   6.903nH   1.274pF
61   Rec_Pwm4   33schmitttrig_cin_p   297.0m   6.794nH   1.294pF
62   Rec_Pwm5   33schmitttrig_cin_p   289.7m   5.731nH   1.325pF
63   GND   GND
64   Rec_Pwm6   33schmitttrig_cin_p   295.4m   5.969nH   1.391pF
65   CHG_Pwm2   33schmitttrig_cin_p   293.4m   6.702nH   1.431pF
66   CHG_Pwm1   33schmitttrig_cin_p   299.7m   6.767nH   1.466pF
67   VCCIO4   POWER
68   GND   GND
69   FAN_Pwm   lvcmos_cio_d2s2   351.8m   6.149nH   1.605pF
7   Inv_Pwm_LMTW   33schmitttrig_rin_p   284.4m   7.583nH   1.470pF
70   CHGPwm_P   lvcmos_cio_d2s2   352.5m   6.730nH   1.630pF
71   VCCA5   POWER
72   VCC_ONE   POWER
73   VCC_ONE   POWER
74   CHGPwm_N   lvcmos_rio_d2s2   344.1m   6.481nH   1.608pF
75   CHGP_SCR   lvttl_rio_d8s2   330.4m   7.096nH   1.620pF
76   CHGN_SCR   lvttl_rio_d8s2   332.5m   7.661nH   1.588pF
77   Inv_KM_DR   lvttl_rio_d8s2   315.4m   7.470nH   1.543pF
78   Inv_STS_DR   lvttl_rio_d8s2   320.0m   7.887nH   1.511pF
79   FAN_Fault   33schmitttrig_rin_p   304.1m   7.494nH   1.477pF
8   Inv_Pwm_LMTV   33schmitttrig_rin_p   275.3m   7.543nH   1.434pF
80   Module_Ready   33schmitttrig_rin_p   311.5m   7.454nH   1.449pF
81   Module_Alarm_LED   lvttl_rio_d8s2   303.9m   6.786nH   1.411pF
82   VCCIO5   POWER
83   GND   GND
84   Rec_Pwm_CN   lvcmos_rio_d2s2   294.1m   5.840nH   1.305pF
85   Rec_Pwm_CP   lvcmos_rio_d2s2   265.4m   6.454nH   1.261pF
86   Inv_Pwm_W4   lvcmos_rio_d2s2   271.5m   6.843nH   1.244pF
87   Inv_Pwm_W3   lvcmos_rio_d2s2   261.1m   6.681nH   1.223pF
88   Inv_Pwm_W2   lvcmos_rio_d2s2   248.7m   6.832nH   1.189pF
89   Inv_Pwm_W1   lvcmos_rio_d2s2   248.1m   6.816nH   1.197pF
9   VCCIO1A   POWER
90   ModuleOK_LED   lvttl_rio_d8s2   253.4m   6.780nH   1.204pF
91   Rec_Pwm_BN   lvcmos_rio_d2s2   265.8m   6.553nH   1.215pF
92   Rec_Pwm_BP   lvcmos_rio_d2s2   276.1m   6.512nH   1.212pF
93   Inv_Pwm_V4   lvcmos_rio_d2s2   283.7m   6.033nH   1.212pF
94   VCCIO6   POWER
95   GND   GND
96   Inv_Pwm_V3   lvcmos_rio_d2s2   269.9m   5.886nH   1.257pF
97   Inv_Pwm_V2   lvcmos_rio_d2s2_vref   287.6m   6.988nH   1.288pF
98   Inv_Pwm_V1   lvcmos_rio_d2s2   264.5m   6.964nH   1.322pF
99   Rec_Pwm_AN   lvcmos_rio_d2s2   269.2m   7.116nH   1.359pF
| Models and submodels in the file (9): 33schmitttrig_cin_p (Input), 33schmitttrig_rin (Input), 33schmitttrig_rin_p (Input), lvcmos_cio_d2s2 (I/O), lvcmos_cio_d2s2_vref (I/O), lvcmos_rio_d2s2 (I/O), lvcmos_rio_d2s2_vref (I/O), lvttl_rio_d8s2 (I/O), lvttl_rio_s2 (I/O)
